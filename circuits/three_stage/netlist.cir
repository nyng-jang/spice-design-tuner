* 3-stage amplifier (CS - CE - CC), 2023 Microelectronic Circuits design project
* Tunable elements are .param values; tuner overrides them.
.param RE2=6.374k RE3=1.3434k
.param RG1=3Meg RG2=1.5Meg R1=2k R2=2k RC2=7.46k R3=50k R4=100k
.param RD1=620 RS1=200 RL=250 RSIG=10k
* coupling (C1 C3 C5 C6) and bypass (C2 C4) capacitors, farads
.param C1=10u C2=10u C3=10u C4=10u C5=10u C6=10u

VCC vcc 0 DC 15
* signal source (AC 1 for small-signal analysis)
VI vs 0 DC 0 AC 1
RSIG vs in {RSIG}
C1 in g1 {C1}
RG1 vcc g1 {RG1}
RG2 g1 0 {RG2}

* --- Stage 1: CS (M1 = 2N7000) ---
M1 d1 g1 s1 s1 M2N7000
RD1 vcc d1 {RD1}
RS1 s1 0 {RS1}
C2 s1 0 {C2}

* --- Stage 2: CE (Q2) ---
C3 d1 b2 {C3}
R1 vcc b2 {R1}
R2 b2 0 {R2}
Q2 c2 b2 e2 Q2
RC2 vcc c2 {RC2}
RE2 e2 0 {RE2}
C4 e2 0 {C4}

* --- Stage 3: CC (Q3) ---
C5 c2 b3 {C5}
R3 vcc b3 {R3}
R4 b3 0 {R4}
Q3 vcc b3 e3 Q3
RE3 e3 0 {RE3}
C6 e3 out {C6}
RL out 0 {RL}
* test current source for Rout (AC 0 during gain/Rin run)
ITEST 0 e3 DC 0 AC 0

* Models
* 2N7000: OrCAD breakout library model (M2N7000)
.model M2N7000 NMOS(Level=3 Gamma=0 Delta=0 Eta=0 Theta=0 Kappa=0.2 Vmax=0 Xj=0
+ Tox=2u Uo=600 Phi=.6 Rs=1.666 Kp=20.87u W=.13 L=2u Vto=2.13 Rd=.8 Rds=24E6
+ Cbd=104.2p Pb=.8 Mj=.5 Fc=.5 Cgso=86.25p Cgdo=2.18p Rg=546.4 Is=58.71f N=1 Tt=145n)
* Q2/Q3: generic models (beta=100, no Early). Course library can be swapped in via the app or sim.simulate(lib_text=...)
.include ../../models/generic.lib
.end
